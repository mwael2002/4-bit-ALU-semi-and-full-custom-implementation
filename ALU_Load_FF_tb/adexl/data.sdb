ADE simulation setup
Run mode: Single Run, Sweeps and Corners
Tests:
  Final_Digital:ALU_Load_FF_tb:1: Final_Digital/ALU_Load_FF_tb/schematic, simulator spectre
